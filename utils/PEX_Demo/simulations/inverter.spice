** sch_path: /home/pedersen/misc/inverter_example/inverter.sch
.SUBCKT inverter Vdd Vin Vout Gnd
*.PININFO Vout:B Vdd:B Vin:B Gnd:B
M1 Vout Vin Gnd net2 sg13_lv_nmos w=1.0u l=0.45u ng=1 m=1
M2 Vout Vin Vdd net1 sg13_lv_pmos w=2.0u l=0.45u ng=1 m=1
R1 Vdd net1 ntap1 A=6.084e-13 P=3.12e-06
R2 Gnd net2 ptap1 A=6.084e-13 P=3.12e-06
.ENDS
