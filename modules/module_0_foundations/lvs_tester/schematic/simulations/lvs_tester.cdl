** sch_path: /home/pedersen/projects/IHP-AnalogAcademy/modules/module_0_foundations/lvs_tester/schematic/lvs_tester.sch
.SUBCKT lvs_tester G D gnd
*.PININFO G:B D:B gnd:B
M3 D G gnd sub sg13_lv_nmos w=1.0u l=0.45u ng=1 m=1
R1 gnd sub ptap1 A=6.084e-13 P=3.12e-06
.ENDS
